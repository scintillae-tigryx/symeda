* SPDX-License-Identifier: GPL-3.0-only
* Copyright (C) 2026 Scintillae Ltd. - symeda.com
* .include resolution relative to the including file
V1 in 0 DC 1
.include "include_child.inc"
.tran 10n 2u
.end
