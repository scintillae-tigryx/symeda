* SPDX-License-Identifier: GPL-3.0-only
* Copyright (C) 2026 Scintillae Ltd. - symeda.com
* Unknown waveform function: parse error with a line number.
V1 a 0 WOBBLE(1 2)
R1 a 0 1k
.tran 1n 1u
.end
