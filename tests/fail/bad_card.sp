* SPDX-License-Identifier: GPL-3.0-only
* Copyright (C) 2026 Scintillae Ltd. - symeda.com
* Truncated element card: must be a parse error, not a crash.
R1 a
.tran 1n 1u
.end
