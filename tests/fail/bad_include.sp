* SPDX-License-Identifier: GPL-3.0-only
* Copyright (C) 2026 Scintillae Ltd. - symeda.com
* .include of a file that does not exist: parse error, not a crash.
V1 in 0 DC 1
.include "no_such_file.inc"
.tran 1n 1u
.end
