* SPDX-License-Identifier: GPL-3.0-only
* Copyright (C) 2026 Scintillae Ltd. - symeda.com
* Legal circuit with no analysis card: the engine must refuse it.
R1 a 0 1k
.end
